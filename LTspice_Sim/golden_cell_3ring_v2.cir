* Prime_Maxel-v3: 3-Cell Ring v2 — Torsion-Sensitive Model
* Purpose: Redesigned coupling so transmission line properties dominate
*          and TORSION_A vs TORSION_B ratio becomes visible
*
* Changes from v1:
*   - Removed RC filter on injection path (was masking line effects)
*   - Direct drive/receive through matched impedance
*   - Added lossy transmission lines (LTRA) with real copper loss
*   - Both A and B rings driven by comparator outputs
*   - Cross-coupling: A-ring feeds B-ring gain stages and vice versa
*
* Adrian / Tusk Innovations — April 2026
* Generated by Nagaπ
*
*==============================================================
* PARAMETERS
*==============================================================
.param VCC=12
.param VREG=5
.param F_BASE=500k
.param F1={F_BASE/13}  ; ~38.5 kHz
.param F2={F_BASE/11}  ; ~45.5 kHz
.param F3={F_BASE/7}   ; ~71.4 kHz
*
* Torsion trace parameters
.param TA_LEN=497.97m  ; TORSION_A total length (metres)
* .param TB_LEN=497.97m  ; TORSION_B total length (metres)
.param TB_LEN=600.56m  ; TORSION_B total length (metres)
.param TA_SEG={TA_LEN/12}
.param TB_SEG={TB_LEN/12}
*
*==============================================================
* LOSSY TRANSMISSION LINE MODELS
* Using LTRA with real physical parameters:
*   Z0=50Ω, FR4 substrate, 2oz Cu, 0.229mm trace width
*   R = copper resistance per metre (~3.7 Ω/m for 0.229mm/2oz)
*   L, C derived from Z0 and velocity
*   G = dielectric loss
*==============================================================
.model TLINE_A LTRA(R={3.7*TA_SEG} L={282e-9*TA_SEG} C={113e-12*TA_SEG} len=1)
.model TLINE_B LTRA(R={3.7*TB_SEG} L={282e-9*TB_SEG} C={113e-12*TB_SEG} len=1)
*
*==============================================================
* POWER SUPPLY
*==============================================================
VCC vcc 0 {VCC}
VREG vreg 0 {VREG}
VMID vmid 0 {VREG/2}
*
*==============================================================
* GREENPAK OSCILLATOR MODELS
*==============================================================
V_OA0_1 oa0_1 0 PULSE(0.5 4.5 0 10n 10n {0.5/F1} {1/F1})
V_OA1_1 oa1_1 0 PULSE(0.5 4.5 {0.25/F1} 10n 10n {0.5/F1} {1/F1})
*
V_OA0_2 oa0_2 0 PULSE(0.5 4.5 0 10n 10n {0.5/F2} {1/F2})
V_OA1_2 oa1_2 0 PULSE(0.5 4.5 {0.25/F2} 10n 10n {0.5/F2} {1/F2})
*
V_OA0_3 oa0_3 0 PULSE(0.5 4.5 0 10n 10n {0.5/F3} {1/F3})
V_OA1_3 oa1_3 0 PULSE(0.5 4.5 {0.25/F3} 10n 10n {0.5/F3} {1/F3})
*
*==============================================================
* CENTRE PULSE INJECTION
*==============================================================
V_PULSE pulse_in 0 PULSE(0 5 50u 10n 10n 1u 0)
*
*==============================================================
* LM324 OP-AMP SUBCIRCUIT
*==============================================================
.include LM324.sub
*
*==============================================================
* CELL 1 — LM324 Signal Conditioning
*==============================================================
* Ch1: Buffer (OA0_OUT)
XU1A oa0_1 buf1_out vreg 0 buf1_out LM324
Rbuf1 buf1_out 0 100k
*
* Ch2: Gain stage — INPUT NOW FROM TORSION_B (cross-coupling!)
Rg1a gain1_fb 0 10k
Rg1b gain1_fb gain1_out 10k
XU1B tb1_in gain1_fb vreg 0 gain1_out LM324
*
* Ch3: Comparator — DRIVES TORSION_A
XU1C gain1_out vmid vreg 0 comp1_out LM324
Rcomp1 comp1_out vreg 10k
*
* Ch4: Pulse summer — DRIVES TORSION_B
* Sums pulse_in with TORSION_A received signal
R_sum1a pulse_in sum1_in 1k
R_sum1b ta1_in sum1_in 1k
XU1D sum1_in vmid vreg 0 drv1_b LM324
Rdrv1b drv1_b 0 100k
*
*==============================================================
* CELL 2 — LM324 Signal Conditioning
*==============================================================
XU2A oa0_2 buf2_out vreg 0 buf2_out LM324
Rbuf2 buf2_out 0 100k
*
Rg2a gain2_fb 0 10k
Rg2b gain2_fb gain2_out 10k
XU2B tb2_in gain2_fb vreg 0 gain2_out LM324
*
XU2C gain2_out vmid vreg 0 comp2_out LM324
Rcomp2 comp2_out vreg 10k
*
R_sum2a pulse_in sum2_in 1k
R_sum2b ta2_in sum2_in 1k
XU2D sum2_in vmid vreg 0 drv2_b LM324
Rdrv2b drv2_b 0 100k
*
*==============================================================
* CELL 3 — LM324 Signal Conditioning
*==============================================================
XU3A oa0_3 buf3_out vreg 0 buf3_out LM324
Rbuf3 buf3_out 0 100k
*
Rg3a gain3_fb 0 10k
Rg3b gain3_fb gain3_out 10k
XU3B tb3_in gain3_fb vreg 0 gain3_out LM324
*
XU3C gain3_out vmid vreg 0 comp3_out LM324
Rcomp3 comp3_out vreg 10k
*
R_sum3a pulse_in sum3_in 1k
R_sum3b ta3_in sum3_in 1k
XU3D sum3_in vmid vreg 0 drv3_b LM324
Rdrv3b drv3_b 0 100k
*
*==============================================================
* TORSION_A RING (Lossy TL) — Driven by comparators
* Signal path: comp_out → 50Ω match → TORSION_A → next cell gain input
*==============================================================
O_A12 ta1_out 0 ta2_in 0 TLINE_A
O_A23 ta2_out 0 ta3_in 0 TLINE_A
O_A31 ta3_out 0 ta1_in 0 TLINE_A
*
* Drive from comparator outputs (matched impedance)
Rta1_drv comp1_out ta1_out 50
Rta2_drv comp2_out ta2_out 50
Rta3_drv comp3_out ta3_out 50
*
* Receive terminations
Rterm_a1 ta1_in 0 50
Rterm_a2 ta2_in 0 50
Rterm_a3 ta3_in 0 50
*
*==============================================================
* TORSION_B RING (Lossy TL) — Driven by Ch4 summers
* Signal path: drv_b → 50Ω match → TORSION_B → next cell gain input
* Cross-coupling: B received signal feeds gain stage (Ch2)
*==============================================================
O_B12 tb1_out 0 tb2_in 0 TLINE_B
O_B23 tb2_out 0 tb3_in 0 TLINE_B
O_B31 tb3_out 0 tb1_in 0 TLINE_B
*
* Drive from Ch4 summer outputs
Rtb1_drv drv1_b tb1_out 50
Rtb2_drv drv2_b tb2_out 50
Rtb3_drv drv3_b tb3_out 50
*
* Receive terminations
Rterm_b1 tb1_in 0 50
Rterm_b2 tb2_in 0 50
Rterm_b3 tb3_in 0 50
*
*==============================================================
* DECOUPLING
*==============================================================
C_dec1 vreg 0 100n
C_dec2 vreg 0 100n
C_dec3 vreg 0 100n
*
*==============================================================
* SIMULATION
*==============================================================
.tran 0 200u 0 10n
*
* Key nodes:
* V(ta1_in), V(ta2_in), V(ta3_in)  — TORSION_A received
* V(tb1_in), V(tb2_in), V(tb3_in)  — TORSION_B received
* V(comp1_out)                       — comparator (A driver)
* V(drv1_b)                          — B driver
* V(gain1_out)                       — cross-coupled gain output
* V(buf1_out)                        — buffered oscillator
*
.end
