* Prime_Maxel-v3: 3-Cell Ring Simulation
* Purpose: Model 3 golden cells connected via torsion traces
*          to observe coupling, oscillation, and ratio sensitivity
*
* Adrian / Tusk Innovations — April 2026
* Generated by Nagaπ
*
*==============================================================
* PARAMETERS (edit these to sweep)
*==============================================================
.param VCC=12          ; Supply voltage
.param VREG=5          ; Regulated voltage for ICs
.param F_BASE=500k     ; Base oscillator frequency
.param F1={F_BASE/13}  ; Node 1: 1/13 ratio (~38.5 kHz)
.param F2={F_BASE/11}  ; Node 2: 1/11 ratio (~45.5 kHz)
.param F3={F_BASE/7}   ; Node 3: 1/7 ratio  (~71.4 kHz)
*
* Torsion trace parameters (from measured board)
.param TA_LEN=497.97m  ; TORSION_A total length in metres (497.97mm)
* .param TB_LEN=497.97m
.param TB_LEN=600.56m  ; TORSION_B total length in metres (600.56mm)
.param TA_SEG={TA_LEN/12} ; Per-cell segment of TORSION_A
.param TB_SEG={TB_LEN/12} ; Per-cell segment of TORSION_B
.param Z0=50           ; Characteristic impedance (ohms)
.param TD_A={TA_SEG*5.64e-9} ; Delay per segment (sqrt(3.18)*L/c)
.param TD_B={TB_SEG*5.64e-9} ; εeff≈3.18 for microstrip on FR4
*
*==============================================================
* POWER SUPPLY
*==============================================================
VCC vcc 0 {VCC}
VREG vreg 0 {VREG}
VMID vmid 0 {VREG/2}   ; Mid-rail reference for single-supply op-amps
*
*==============================================================
* GREENPAK OSCILLATOR MODELS (behavioural)
* Each GreenPAK is modelled as:
*   - A pulse source (OA0_OUT) at its prime-ratio frequency
*   - A second pulse source (OA1_OUT) at same freq, 90° shifted
*   - A digital input (GPIO0) that gates the output
*==============================================================
*
* --- Cell 1: N1 = 1/13 ratio ---
V_OA0_1 oa0_1 0 PULSE(0.5 4.5 0 10n 10n {0.5/F1} {1/F1})
V_OA1_1 oa1_1 0 PULSE(0.5 4.5 {0.25/F1} 10n 10n {0.5/F1} {1/F1})
*
* --- Cell 2: N2 = 1/11 ratio ---
V_OA0_2 oa0_2 0 PULSE(0.5 4.5 0 10n 10n {0.5/F2} {1/F2})
V_OA1_2 oa1_2 0 PULSE(0.5 4.5 {0.25/F2} 10n 10n {0.5/F2} {1/F2})
*
* --- Cell 3: N3 = 1/7 ratio ---
V_OA0_3 oa0_3 0 PULSE(0.5 4.5 0 10n 10n {0.5/F3} {1/F3})
V_OA1_3 oa1_3 0 PULSE(0.5 4.5 {0.25/F3} 10n 10n {0.5/F3} {1/F3})
*
*==============================================================
* CENTRE PULSE INJECTION (Arduino pin 22)
* Single pulse to test revival
*==============================================================
V_PULSE pulse_in 0 PULSE(0 5 50u 10n 10n 1u 0)
* V_PULSE pulse_in 0 0
*
*==============================================================
* LM324 OP-AMP SUBCIRCUIT
*==============================================================
.include LM324.sub
*
*==============================================================
* CELL 1 — LM324 Signal Conditioning
*==============================================================
* Ch1: Buffer (OA0_OUT → non-inv buffer)
XU1A oa0_1 buf1_out vreg 0 buf1_out LM324
Rbuf1 buf1_out 0 100k
*
* Ch2: Non-inverting gain stage (gain ≈ 2), input from OA1 + torsion coupling
Rg1a gain1_fb 0 10k
Rg1b gain1_fb gain1_out 10k
XU1B gain1_in gain1_fb vreg 0 gain1_out LM324
Rbias1 gain1_in vmid 100k
*
* Ch3: Comparator (compares gain output to mid-rail)
XU1C gain1_out vmid vreg 0 comp1_out LM324
Rcomp1 comp1_out vreg 10k
*
* Ch4: Pulse injection stage
Rinj1 pulse_in inj1_in 10k
Cinj1 inj1_in 0 100p
XU1D inj1_in vmid vreg 0 inj1_out LM324
Rinj1o inj1_out 0 100k
*
*==============================================================
* CELL 2 — LM324 Signal Conditioning
*==============================================================
XU2A oa0_2 buf2_out vreg 0 buf2_out LM324
Rbuf2 buf2_out 0 100k
*
Rg2a gain2_fb 0 10k
Rg2b gain2_fb gain2_out 10k
XU2B gain2_in gain2_fb vreg 0 gain2_out LM324
Rbias2 gain2_in vmid 100k
*
XU2C gain2_out vmid vreg 0 comp2_out LM324
Rcomp2 comp2_out vreg 10k
*
Rinj2 pulse_in inj2_in 10k
Cinj2 inj2_in 0 100p
XU2D inj2_in vmid vreg 0 inj2_out LM324
Rinj2o inj2_out 0 100k
*
*==============================================================
* CELL 3 — LM324 Signal Conditioning
*==============================================================
XU3A oa0_3 buf3_out vreg 0 buf3_out LM324
Rbuf3 buf3_out 0 100k
*
Rg3a gain3_fb 0 10k
Rg3b gain3_fb gain3_out 10k
XU3B gain3_in gain3_fb vreg 0 gain3_out LM324
Rbias3 gain3_in vmid 100k
*
XU3C gain3_out vmid vreg 0 comp3_out LM324
Rcomp3 comp3_out vreg 10k
*
Rinj3 pulse_in inj3_in 10k
Cinj3 inj3_in 0 100p
XU3D inj3_in vmid vreg 0 inj3_out LM324
Rinj3o inj3_out 0 100k
*
*==============================================================
* TORSION BRIDGE TRACES (Transmission Lines)
* TORSION_A: Inner ring (cell-to-cell segments)
* TORSION_B: Outer ring (cell-to-cell segments)
*==============================================================
*
* TORSION_A ring: Cell1 → Cell2 → Cell3 → Cell1
T_A12 ta1_out 0 ta2_in 0 Z0=50 TD={TD_A}
T_A23 ta2_out 0 ta3_in 0 Z0=50 TD={TD_A}
T_A31 ta3_out 0 ta1_in 0 Z0=50 TD={TD_A}
*
* TORSION_B ring: Cell1 → Cell2 → Cell3 → Cell1
T_B12 tb1_out 0 tb2_in 0 Z0=50 TD={TD_B}
T_B23 tb2_out 0 tb3_in 0 Z0=50 TD={TD_B}
T_B31 tb3_out 0 tb1_in 0 Z0=50 TD={TD_B}
*
* Connect cell outputs to torsion traces
* (comp output drives the torsion ring, buffer input receives)
*
* Cell 1 connections
Rta1_drv comp1_out ta1_out 50
Rta1_rcv ta1_in gain1_in 1k
Rtb1_drv inj1_out tb1_out 50
Rtb1_rcv tb1_in inj1_in 1k
*
* Cell 2 connections
Rta2_drv comp2_out ta2_out 50
Rta2_rcv ta2_in gain2_in 1k
Rtb2_drv inj2_out tb2_out 50
Rtb2_rcv tb2_in inj2_in 1k
*
* Cell 3 connections
Rta3_drv comp3_out ta3_out 50
Rta3_rcv ta3_in gain3_in 1k
Rtb3_drv inj3_out tb3_out 50
Rtb3_rcv tb3_in inj3_in 1k
*
* Termination resistors on torsion lines (prevent reflections)
Rterm_a1 ta1_in 0 50
Rterm_a2 ta2_in 0 50
Rterm_a3 ta3_in 0 50
Rterm_b1 tb1_in 0 50
Rterm_b2 tb2_in 0 50
Rterm_b3 tb3_in 0 50
*
*==============================================================
* DECOUPLING CAPACITORS (0.1µF per cell, as on board)
*==============================================================
C_dec1 vreg 0 100n
C_dec2 vreg 0 100n
C_dec3 vreg 0 100n
*
*==============================================================
* SIMULATION COMMANDS
*==============================================================
* Transient: Run for 200µs, observe oscillation & pulse revival
.tran 0 1m 0 10n
* .tran 0 200u 0 10n
*
* Key nodes to plot:
* V(buf1_out), V(buf2_out), V(buf3_out)     — buffered oscillator outputs
* V(gain1_out), V(gain2_out), V(gain3_out)   — amplified signals
* V(comp1_out), V(comp2_out), V(comp3_out)   — comparator outputs
* V(ta1_in), V(ta2_in), V(ta3_in)            — TORSION_A received signals
* V(tb1_in), V(tb2_in), V(tb3_in)            — TORSION_B received signals
* V(pulse_in)                                  — centre pulse injection
*
* Measurements:
.meas TRAN revival_1 MAX V(buf1_out) FROM=50u TO=60u
.meas TRAN revival_2 MAX V(buf2_out) FROM=50u TO=60u
.meas TRAN revival_3 MAX V(buf3_out) FROM=50u TO=60u
.meas TRAN freq_1 FIND V(comp1_out) AT=100u
.meas TRAN freq_2 FIND V(comp2_out) AT=100u
.meas TRAN freq_3 FIND V(comp3_out) AT=100u
*
* Phase measurement between torsion outputs
.meas TRAN ta_delay TRIG V(ta1_out) VAL=2.5 RISE=10 TARG V(ta2_in) VAL=2.5 RISE=10
.meas TRAN tb_delay TRIG V(tb1_out) VAL=2.5 RISE=10 TARG V(tb2_in) VAL=2.5 RISE=10
*
.end
